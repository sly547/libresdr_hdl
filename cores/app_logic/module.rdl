// Copyright (c) 2026 Michael Büchler
// All Rights Reserved.
addrmap app_logic_reg {
  reg {
    name="Frequencies";
    field {
      sw=r;
      hw=w;
    } data[32];
  } clock_freq[4];

  reg {
    field {
      name="Video subsystem reset";
      sw=rw;
      hw=r;
    } rst[1];
    field {
      name = "Select video data at DAC channel 1 input";
      sw = rw;
      hw = r;
      swmod;
    } sel[1];
  } video;
};
