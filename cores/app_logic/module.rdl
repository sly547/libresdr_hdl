addrmap app_logic_reg {
  reg {
    name="Frequencies";
    field {
      sw=r;
      hw=w;
    } data[32];
  } clock_freq[4];

  reg {
    field {
      name="Video subsystem reset";
      sw=rw;
      hw=r;
    } rst[1];
  } video;
};
